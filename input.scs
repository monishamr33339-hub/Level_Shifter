// Design: level_shifter/level_shifter_cascode
simulator lang=spectre
global 0
include "/home/work/gpdk090_v4.6/libs.oa22/gpdk090/../../models/spectre/gpdk090.scs" section=NN

// level_shifter/level_shifter_cascode/schematic
NM1 (net22 IN_B 0 0) gpdk090_nmos1v w=(3u) l=100n m=(1)*(1) simM=(1)*(1)
NM0 (net23 IN 0 0) gpdk090_nmos1v w=(3u) l=100n m=(1)*(1) simM=(1)*(1)
M1 (OUT VDDL net22 0) gpdk090_nmos2v w=(800n) l=280n m=(1)*(1) simM=(1)*(1)
M0 (net11 VDDL net23 0) gpdk090_nmos2v w=(800n) l=280n m=(1)*(1) simM=(1)*(1)
M3 (OUT net11 VDDH VDDH) gpdk090_pmos2v w=(500n) l=500n m=(1)*(1) simM=(1)*(1)
M2 (net11 OUT VDDH VDDH) gpdk090_pmos2v w=(500n) l=500n m=(1)*(1) simM=(1)*(1)
include "./_graphical_stimuli.scs"
simulatorOptions options temp=27
tran tran stop=100n
saveOptions options pwr=all
